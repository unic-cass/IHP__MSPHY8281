** sch_path: /home/admin/work/IHP__MSPHY8281/MSPHY8281-main/schematic/xschem/user_project_wrapper.sch
**.subckt user_project_wrapper analog_io[8] analog_io[6] analog_io[11] ui_PAD[0] analog_io[10] analog_io[7] analog_io[9]
*+ analog_io[4] analog_io[5] analog_io_padres[4] analog_io_padres[11] analog_io_padres[5] analog_io_padres[6] ui_p2c[0] analog_io_padres[10]
*+ analog_io_padres[7] analog_io_padres[8] analog_io_padres[9] analog_io_padres[12] analog_io[3] analog_io[12] analog_io_padres[3] analog_io_padres[13]
*+ analog_io[2] analog_io[13] analog_io_padres[2] ui_p2c[1] analog_io[1] ui_PAD[1] analog_io_padres[1] analog_io_padres[14] analog_io[0]
*+ analog_io[14] analog_io_padres[0] analog_io_padres[15] uo_PAD[8] analog_io[15] analog_io_padres[16] uo_PAD[7] analog_io[16] uo_c2p[7] ui_p2c[2]
*+ uo_PAD[6] ui_PAD[2] uo_c2p[6] ui_p2c[3] uo_PAD[5] ui_PAD[3] uo_c2p[5] ui_p2c[4] uo_PAD[4] ui_PAD[4] uo_c2p[4] ui_p2c[5] ui_p2c[6] uo_c2p[0]
*+ uo_c2p[1] uo_c2p[2] uo_c2p[3] analog_io_padres[17] analog_io_padres[18] analog_io_padres[19] VSS VDD IOVDD IOVSS analog_io[19]
*+ analog_io[18] analog_io[17] uo_PAD[3] uo_PAD[2] uo_PAD[1] uo_PAD[0] ui_PAD[6] ui_PAD[5] uo_c2p[8]
*.iopin VSS
*.iopin VDD
*.iopin IOVDD
*.iopin IOVSS
*.iopin uo_PAD[4]
*.iopin uo_PAD[5]
*.iopin uo_PAD[6]
*.iopin uo_PAD[7]
*.iopin uo_PAD[8]
*.iopin analog_io[0]
*.iopin analog_io[1]
*.iopin analog_io[2]
*.iopin analog_io[3]
*.iopin analog_io[4]
*.iopin analog_io[5]
*.iopin analog_io[6]
*.iopin analog_io[7]
*.iopin analog_io[8]
*.iopin analog_io[9]
*.iopin ui_PAD[0]
*.iopin analog_io[10]
*.iopin analog_io[11]
*.iopin analog_io[12]
*.iopin analog_io[13]
*.iopin ui_PAD[1]
*.iopin analog_io[14]
*.iopin analog_io[15]
*.iopin analog_io[16]
*.iopin ui_PAD[2]
*.iopin ui_PAD[3]
*.iopin ui_PAD[4]
*.iopin ui_PAD[5]
*.iopin ui_PAD[6]
*.iopin uo_PAD[0]
*.iopin uo_PAD[1]
*.iopin uo_PAD[2]
*.iopin uo_PAD[3]
*.iopin analog_io[17]
*.iopin analog_io[18]
*.iopin analog_io[19]
*.iopin analog_io_padres[3]
*.iopin analog_io_padres[2]
*.iopin analog_io_padres[1]
*.iopin analog_io_padres[0]
*.iopin uo_c2p[8]
*.iopin uo_c2p[7]
*.iopin uo_c2p[6]
*.iopin uo_c2p[5]
*.iopin uo_c2p[4]
*.iopin analog_io_padres[19]
*.iopin analog_io_padres[18]
*.iopin analog_io_padres[17]
*.iopin uo_c2p[3]
*.iopin uo_c2p[2]
*.iopin uo_c2p[1]
*.iopin uo_c2p[0]
*.iopin ui_p2c[6]
*.iopin ui_p2c[5]
*.iopin ui_p2c[4]
*.iopin ui_p2c[3]
*.iopin ui_p2c[2]
*.iopin analog_io_padres[16]
*.iopin analog_io_padres[15]
*.iopin analog_io_padres[14]
*.iopin ui_p2c[1]
*.iopin analog_io_padres[13]
*.iopin analog_io_padres[12]
*.iopin analog_io_padres[11]
*.iopin analog_io_padres[10]
*.iopin ui_p2c[0]
*.iopin analog_io_padres[9]
*.iopin analog_io_padres[8]
*.iopin analog_io_padres[7]
*.iopin analog_io_padres[6]
*.iopin analog_io_padres[5]
*.iopin analog_io_padres[4]
x5 IOVDD VDD VSS SUB IOVSS IOVSS IOVSS sg13g2_Corner_noptap
x6 IOVDD VSS analog_io[19] VDD SUB analog_io_padres[19] IOVSS IOVDD sg13g2_IOPadAnalog
x10 VSS VDD SUB IOVSS IOVDD IOVSS sg13g2_IOPadVss
x11[7] IOVDD IOVSS VDD IOVSS IOVSS VSS SUB sg13g2_Filler4000
x11[6] IOVDD IOVSS VDD IOVSS IOVSS VSS SUB sg13g2_Filler4000
x11[5] IOVDD IOVSS VDD IOVSS IOVSS VSS SUB sg13g2_Filler4000
x11[4] IOVDD IOVSS VDD IOVSS IOVSS VSS SUB sg13g2_Filler4000
x11[3] IOVDD IOVSS VDD IOVSS IOVSS VSS SUB sg13g2_Filler4000
x11[2] IOVDD IOVSS VDD IOVSS IOVSS VSS SUB sg13g2_Filler4000
x11[1] IOVDD IOVSS VDD IOVSS IOVSS VSS SUB sg13g2_Filler4000
x11[0] IOVDD IOVSS VDD IOVSS IOVSS VSS SUB sg13g2_Filler4000
x12[7] IOVDD IOVSS VDD IOVSS IOVSS VSS SUB sg13g2_Filler1000
x12[6] IOVDD IOVSS VDD IOVSS IOVSS VSS SUB sg13g2_Filler1000
x12[5] IOVDD IOVSS VDD IOVSS IOVSS VSS SUB sg13g2_Filler1000
x12[4] IOVDD IOVSS VDD IOVSS IOVSS VSS SUB sg13g2_Filler1000
x12[3] IOVDD IOVSS VDD IOVSS IOVSS VSS SUB sg13g2_Filler1000
x12[2] IOVDD IOVSS VDD IOVSS IOVSS VSS SUB sg13g2_Filler1000
x12[1] IOVDD IOVSS VDD IOVSS IOVSS VSS SUB sg13g2_Filler1000
x12[0] IOVDD IOVSS VDD IOVSS IOVSS VSS SUB sg13g2_Filler1000
x13[7] IOVDD IOVSS VDD IOVSS IOVSS VSS SUB sg13g2_Filler400
x13[6] IOVDD IOVSS VDD IOVSS IOVSS VSS SUB sg13g2_Filler400
x13[5] IOVDD IOVSS VDD IOVSS IOVSS VSS SUB sg13g2_Filler400
x13[4] IOVDD IOVSS VDD IOVSS IOVSS VSS SUB sg13g2_Filler400
x13[3] IOVDD IOVSS VDD IOVSS IOVSS VSS SUB sg13g2_Filler400
x13[2] IOVDD IOVSS VDD IOVSS IOVSS VSS SUB sg13g2_Filler400
x13[1] IOVDD IOVSS VDD IOVSS IOVSS VSS SUB sg13g2_Filler400
x13[0] IOVDD IOVSS VDD IOVSS IOVSS VSS SUB sg13g2_Filler400
x14[7] IOVDD IOVSS VDD IOVSS IOVSS VSS SUB sg13g2_Filler200
x14[6] IOVDD IOVSS VDD IOVSS IOVSS VSS SUB sg13g2_Filler200
x14[5] IOVDD IOVSS VDD IOVSS IOVSS VSS SUB sg13g2_Filler200
x14[4] IOVDD IOVSS VDD IOVSS IOVSS VSS SUB sg13g2_Filler200
x14[3] IOVDD IOVSS VDD IOVSS IOVSS VSS SUB sg13g2_Filler200
x14[2] IOVDD IOVSS VDD IOVSS IOVSS VSS SUB sg13g2_Filler200
x14[1] IOVDD IOVSS VDD IOVSS IOVSS VSS SUB sg13g2_Filler200
x14[0] IOVDD IOVSS VDD IOVSS IOVSS VSS SUB sg13g2_Filler200
x15 VSS VDD SUB IOVSS IOVDD IOVSS sg13g2_IOPadVdd
x16[47] IOVDD IOVSS VDD IOVSS IOVSS VSS SUB sg13g2_Filler4000
x16[46] IOVDD IOVSS VDD IOVSS IOVSS VSS SUB sg13g2_Filler4000
x16[45] IOVDD IOVSS VDD IOVSS IOVSS VSS SUB sg13g2_Filler4000
x16[44] IOVDD IOVSS VDD IOVSS IOVSS VSS SUB sg13g2_Filler4000
x16[43] IOVDD IOVSS VDD IOVSS IOVSS VSS SUB sg13g2_Filler4000
x16[42] IOVDD IOVSS VDD IOVSS IOVSS VSS SUB sg13g2_Filler4000
x16[41] IOVDD IOVSS VDD IOVSS IOVSS VSS SUB sg13g2_Filler4000
x16[40] IOVDD IOVSS VDD IOVSS IOVSS VSS SUB sg13g2_Filler4000
x16[39] IOVDD IOVSS VDD IOVSS IOVSS VSS SUB sg13g2_Filler4000
x16[38] IOVDD IOVSS VDD IOVSS IOVSS VSS SUB sg13g2_Filler4000
x16[37] IOVDD IOVSS VDD IOVSS IOVSS VSS SUB sg13g2_Filler4000
x16[36] IOVDD IOVSS VDD IOVSS IOVSS VSS SUB sg13g2_Filler4000
x16[35] IOVDD IOVSS VDD IOVSS IOVSS VSS SUB sg13g2_Filler4000
x16[34] IOVDD IOVSS VDD IOVSS IOVSS VSS SUB sg13g2_Filler4000
x16[33] IOVDD IOVSS VDD IOVSS IOVSS VSS SUB sg13g2_Filler4000
x16[32] IOVDD IOVSS VDD IOVSS IOVSS VSS SUB sg13g2_Filler4000
x16[31] IOVDD IOVSS VDD IOVSS IOVSS VSS SUB sg13g2_Filler4000
x16[30] IOVDD IOVSS VDD IOVSS IOVSS VSS SUB sg13g2_Filler4000
x16[29] IOVDD IOVSS VDD IOVSS IOVSS VSS SUB sg13g2_Filler4000
x16[28] IOVDD IOVSS VDD IOVSS IOVSS VSS SUB sg13g2_Filler4000
x16[27] IOVDD IOVSS VDD IOVSS IOVSS VSS SUB sg13g2_Filler4000
x16[26] IOVDD IOVSS VDD IOVSS IOVSS VSS SUB sg13g2_Filler4000
x16[25] IOVDD IOVSS VDD IOVSS IOVSS VSS SUB sg13g2_Filler4000
x16[24] IOVDD IOVSS VDD IOVSS IOVSS VSS SUB sg13g2_Filler4000
x16[23] IOVDD IOVSS VDD IOVSS IOVSS VSS SUB sg13g2_Filler4000
x16[22] IOVDD IOVSS VDD IOVSS IOVSS VSS SUB sg13g2_Filler4000
x16[21] IOVDD IOVSS VDD IOVSS IOVSS VSS SUB sg13g2_Filler4000
x16[20] IOVDD IOVSS VDD IOVSS IOVSS VSS SUB sg13g2_Filler4000
x16[19] IOVDD IOVSS VDD IOVSS IOVSS VSS SUB sg13g2_Filler4000
x16[18] IOVDD IOVSS VDD IOVSS IOVSS VSS SUB sg13g2_Filler4000
x16[17] IOVDD IOVSS VDD IOVSS IOVSS VSS SUB sg13g2_Filler4000
x16[16] IOVDD IOVSS VDD IOVSS IOVSS VSS SUB sg13g2_Filler4000
x16[15] IOVDD IOVSS VDD IOVSS IOVSS VSS SUB sg13g2_Filler4000
x16[14] IOVDD IOVSS VDD IOVSS IOVSS VSS SUB sg13g2_Filler4000
x16[13] IOVDD IOVSS VDD IOVSS IOVSS VSS SUB sg13g2_Filler4000
x16[12] IOVDD IOVSS VDD IOVSS IOVSS VSS SUB sg13g2_Filler4000
x16[11] IOVDD IOVSS VDD IOVSS IOVSS VSS SUB sg13g2_Filler4000
x16[10] IOVDD IOVSS VDD IOVSS IOVSS VSS SUB sg13g2_Filler4000
x16[9] IOVDD IOVSS VDD IOVSS IOVSS VSS SUB sg13g2_Filler4000
x16[8] IOVDD IOVSS VDD IOVSS IOVSS VSS SUB sg13g2_Filler4000
x16[7] IOVDD IOVSS VDD IOVSS IOVSS VSS SUB sg13g2_Filler4000
x16[6] IOVDD IOVSS VDD IOVSS IOVSS VSS SUB sg13g2_Filler4000
x16[5] IOVDD IOVSS VDD IOVSS IOVSS VSS SUB sg13g2_Filler4000
x16[4] IOVDD IOVSS VDD IOVSS IOVSS VSS SUB sg13g2_Filler4000
x16[3] IOVDD IOVSS VDD IOVSS IOVSS VSS SUB sg13g2_Filler4000
x16[2] IOVDD IOVSS VDD IOVSS IOVSS VSS SUB sg13g2_Filler4000
x16[1] IOVDD IOVSS VDD IOVSS IOVSS VSS SUB sg13g2_Filler4000
x16[0] IOVDD IOVSS VDD IOVSS IOVSS VSS SUB sg13g2_Filler4000
x17[47] IOVDD IOVSS VDD IOVSS IOVSS VSS SUB sg13g2_Filler400
x17[46] IOVDD IOVSS VDD IOVSS IOVSS VSS SUB sg13g2_Filler400
x17[45] IOVDD IOVSS VDD IOVSS IOVSS VSS SUB sg13g2_Filler400
x17[44] IOVDD IOVSS VDD IOVSS IOVSS VSS SUB sg13g2_Filler400
x17[43] IOVDD IOVSS VDD IOVSS IOVSS VSS SUB sg13g2_Filler400
x17[42] IOVDD IOVSS VDD IOVSS IOVSS VSS SUB sg13g2_Filler400
x17[41] IOVDD IOVSS VDD IOVSS IOVSS VSS SUB sg13g2_Filler400
x17[40] IOVDD IOVSS VDD IOVSS IOVSS VSS SUB sg13g2_Filler400
x17[39] IOVDD IOVSS VDD IOVSS IOVSS VSS SUB sg13g2_Filler400
x17[38] IOVDD IOVSS VDD IOVSS IOVSS VSS SUB sg13g2_Filler400
x17[37] IOVDD IOVSS VDD IOVSS IOVSS VSS SUB sg13g2_Filler400
x17[36] IOVDD IOVSS VDD IOVSS IOVSS VSS SUB sg13g2_Filler400
x17[35] IOVDD IOVSS VDD IOVSS IOVSS VSS SUB sg13g2_Filler400
x17[34] IOVDD IOVSS VDD IOVSS IOVSS VSS SUB sg13g2_Filler400
x17[33] IOVDD IOVSS VDD IOVSS IOVSS VSS SUB sg13g2_Filler400
x17[32] IOVDD IOVSS VDD IOVSS IOVSS VSS SUB sg13g2_Filler400
x17[31] IOVDD IOVSS VDD IOVSS IOVSS VSS SUB sg13g2_Filler400
x17[30] IOVDD IOVSS VDD IOVSS IOVSS VSS SUB sg13g2_Filler400
x17[29] IOVDD IOVSS VDD IOVSS IOVSS VSS SUB sg13g2_Filler400
x17[28] IOVDD IOVSS VDD IOVSS IOVSS VSS SUB sg13g2_Filler400
x17[27] IOVDD IOVSS VDD IOVSS IOVSS VSS SUB sg13g2_Filler400
x17[26] IOVDD IOVSS VDD IOVSS IOVSS VSS SUB sg13g2_Filler400
x17[25] IOVDD IOVSS VDD IOVSS IOVSS VSS SUB sg13g2_Filler400
x17[24] IOVDD IOVSS VDD IOVSS IOVSS VSS SUB sg13g2_Filler400
x17[23] IOVDD IOVSS VDD IOVSS IOVSS VSS SUB sg13g2_Filler400
x17[22] IOVDD IOVSS VDD IOVSS IOVSS VSS SUB sg13g2_Filler400
x17[21] IOVDD IOVSS VDD IOVSS IOVSS VSS SUB sg13g2_Filler400
x17[20] IOVDD IOVSS VDD IOVSS IOVSS VSS SUB sg13g2_Filler400
x17[19] IOVDD IOVSS VDD IOVSS IOVSS VSS SUB sg13g2_Filler400
x17[18] IOVDD IOVSS VDD IOVSS IOVSS VSS SUB sg13g2_Filler400
x17[17] IOVDD IOVSS VDD IOVSS IOVSS VSS SUB sg13g2_Filler400
x17[16] IOVDD IOVSS VDD IOVSS IOVSS VSS SUB sg13g2_Filler400
x17[15] IOVDD IOVSS VDD IOVSS IOVSS VSS SUB sg13g2_Filler400
x17[14] IOVDD IOVSS VDD IOVSS IOVSS VSS SUB sg13g2_Filler400
x17[13] IOVDD IOVSS VDD IOVSS IOVSS VSS SUB sg13g2_Filler400
x17[12] IOVDD IOVSS VDD IOVSS IOVSS VSS SUB sg13g2_Filler400
x17[11] IOVDD IOVSS VDD IOVSS IOVSS VSS SUB sg13g2_Filler400
x17[10] IOVDD IOVSS VDD IOVSS IOVSS VSS SUB sg13g2_Filler400
x17[9] IOVDD IOVSS VDD IOVSS IOVSS VSS SUB sg13g2_Filler400
x17[8] IOVDD IOVSS VDD IOVSS IOVSS VSS SUB sg13g2_Filler400
x17[7] IOVDD IOVSS VDD IOVSS IOVSS VSS SUB sg13g2_Filler400
x17[6] IOVDD IOVSS VDD IOVSS IOVSS VSS SUB sg13g2_Filler400
x17[5] IOVDD IOVSS VDD IOVSS IOVSS VSS SUB sg13g2_Filler400
x17[4] IOVDD IOVSS VDD IOVSS IOVSS VSS SUB sg13g2_Filler400
x17[3] IOVDD IOVSS VDD IOVSS IOVSS VSS SUB sg13g2_Filler400
x17[2] IOVDD IOVSS VDD IOVSS IOVSS VSS SUB sg13g2_Filler400
x17[1] IOVDD IOVSS VDD IOVSS IOVSS VSS SUB sg13g2_Filler400
x17[0] IOVDD IOVSS VDD IOVSS IOVSS VSS SUB sg13g2_Filler400
x1 IOVDD VSS analog_io[18] VDD SUB analog_io_padres[18] IOVSS IOVDD sg13g2_IOPadAnalog
x2 IOVDD VSS analog_io[17] VDD SUB analog_io_padres[17] IOVSS IOVDD sg13g2_IOPadAnalog
x7 IOVDD VDD VSS SUB IOVSS IOVSS IOVSS sg13g2_Corner_noptap
x21 IOVDD VSS analog_io[16] VDD SUB analog_io_padres[16] IOVSS IOVDD sg13g2_IOPadAnalog
x22 IOVDD VSS analog_io[15] VDD SUB analog_io_padres[15] IOVSS IOVDD sg13g2_IOPadAnalog
x23 IOVDD VSS analog_io[14] VDD SUB analog_io_padres[14] IOVSS IOVDD sg13g2_IOPadAnalog
x25 IOVDD VSS analog_io[13] VDD SUB analog_io_padres[13] IOVSS IOVDD sg13g2_IOPadAnalog
x26 IOVDD VSS analog_io[12] VDD SUB analog_io_padres[12] IOVSS IOVDD sg13g2_IOPadAnalog
* noconn VSS
* noconn VDD
* noconn IOVDD
* noconn IOVSS
* noconn SUB
x29 IOVDD VDD VSS SUB IOVSS IOVSS IOVSS sg13g2_Corner_noptap
x30 IOVDD VSS analog_io[11] VDD SUB analog_io_padres[11] IOVSS IOVDD sg13g2_IOPadAnalog
x31 VSS VDD SUB IOVSS IOVDD IOVSS sg13g2_IOPadIOVdd
x32 VSS VDD SUB IOVSS IOVDD sg13g2_IOPadIOVss
x33 IOVDD VSS analog_io[10] VDD SUB analog_io_padres[10] IOVSS IOVDD sg13g2_IOPadAnalog
x35 IOVDD VSS analog_io[9] VDD SUB analog_io_padres[9] IOVSS IOVDD sg13g2_IOPadAnalog
x36 IOVDD VSS analog_io[8] VDD SUB analog_io_padres[8] IOVSS IOVDD sg13g2_IOPadAnalog
x37 IOVDD VSS analog_io[7] VDD SUB analog_io_padres[7] IOVSS IOVDD sg13g2_IOPadAnalog
x38 IOVDD VSS analog_io[6] VDD SUB analog_io_padres[6] IOVSS IOVDD sg13g2_IOPadAnalog
x39 IOVDD VSS analog_io[5] VDD SUB analog_io_padres[5] IOVSS IOVDD sg13g2_IOPadAnalog
x40 IOVDD VSS analog_io[4] VDD SUB analog_io_padres[4] IOVSS IOVDD sg13g2_IOPadAnalog
* noconn VSS
* noconn VDD
* noconn IOVDD
* noconn IOVSS
* noconn SUB
x43 IOVDD VDD VSS SUB IOVSS IOVSS IOVSS sg13g2_Corner_noptap
x44 IOVDD VSS analog_io[3] VDD SUB analog_io_padres[3] IOVSS IOVDD sg13g2_IOPadAnalog
x45 VSS VDD SUB IOVSS IOVDD IOVSS sg13g2_IOPadIOVdd
x46 VSS VDD SUB IOVSS IOVDD sg13g2_IOPadIOVss
x47 IOVDD VSS analog_io[2] VDD SUB analog_io_padres[2] IOVSS IOVDD sg13g2_IOPadAnalog
x48 IOVDD VSS analog_io[1] VDD SUB analog_io_padres[1] IOVSS IOVDD sg13g2_IOPadAnalog
x49 IOVDD VSS analog_io[0] VDD SUB analog_io_padres[0] IOVSS IOVDD sg13g2_IOPadAnalog
x55 VSS VDD SUB IOVSS IOVDD IOVSS sg13g2_IOPadVdd
x56 VSS VDD SUB IOVSS IOVDD IOVSS sg13g2_IOPadVss
* noconn VSS
* noconn VDD
* noconn IOVDD
* noconn IOVSS
* noconn SUB
XR4 VSS SUB ptap1 R=11.96 w=7.27e-6 l=7.27e-6
XR1 IOVSS SUB ptap1 R=0.02362 w=201.69e-6 l=201.69e-6
x57 VSS VDD SUB IOVSS IOVDD IOVSS ui_PAD[0] ui_p2c[0] sg13g2_IOPadIn
x34 VSS VDD SUB IOVSS IOVDD IOVSS ui_PAD[1] ui_p2c[1] sg13g2_IOPadIn
x24 VSS VDD SUB IOVSS IOVDD IOVSS ui_PAD[2] ui_p2c[2] sg13g2_IOPadIn
x19 VSS VDD SUB IOVSS IOVDD IOVSS ui_PAD[3] ui_p2c[3] sg13g2_IOPadIn
x8 VSS VDD SUB IOVSS IOVDD IOVSS ui_PAD[4] ui_p2c[4] sg13g2_IOPadIn
x20 VSS VDD SUB IOVSS IOVDD IOVSS ui_PAD[5] ui_p2c[5] sg13g2_IOPadIn
x13 VSS VDD SUB IOVSS IOVDD IOVSS ui_PAD[6] ui_p2c[6] sg13g2_IOPadIn
x14 VSS VDD SUB IOVSS IOVDD uo_c2p[0] uo_PAD[0] IOVDD sg13g2_IOPadOut30mA
x11 VSS VDD SUB IOVSS IOVDD uo_c2p[1] uo_PAD[1] IOVDD sg13g2_IOPadOut30mA
x3 VSS VDD SUB IOVSS IOVDD uo_c2p[2] uo_PAD[2] IOVDD sg13g2_IOPadOut30mA
x4 VSS VDD SUB IOVSS IOVDD uo_c2p[3] uo_PAD[3] IOVDD sg13g2_IOPadOut30mA
x12 VSS VDD SUB IOVSS IOVDD uo_c2p[4] uo_PAD[4] IOVDD sg13g2_IOPadOut30mA
x53 VSS VDD SUB IOVSS IOVDD uo_c2p[5] uo_PAD[5] IOVDD sg13g2_IOPadOut30mA
x52 VSS VDD SUB IOVSS IOVDD uo_c2p[6] uo_PAD[6] IOVDD sg13g2_IOPadOut30mA
x51 VSS VDD SUB IOVSS IOVDD uo_c2p[7] uo_PAD[7] IOVDD sg13g2_IOPadOut30mA
x50 VSS VDD SUB IOVSS IOVDD uo_c2p[8] uo_PAD[8] IOVDD sg13g2_IOPadOut30mA
x54 VSS VDD SUB IOVSS IOVDD IOVSS sg13g2_IOPadIOVdd
x58 VSS VDD SUB IOVSS IOVDD sg13g2_IOPadIOVss
x16 VSS VDD SUB IOVSS IOVDD sg13g2_IOPadIOVss
x17 VSS VDD SUB IOVSS IOVDD IOVSS sg13g2_IOPadIOVdd
x9 VSS VDD SUB IOVSS IOVDD IOVSS sg13g2_IOPadVss
x18 VSS VDD SUB IOVSS IOVDD IOVSS sg13g2_IOPadVdd
x27 VSS VDD SUB IOVSS IOVDD sg13g2_IOPadIOVss
x28 VSS VDD SUB IOVSS IOVDD IOVSS sg13g2_IOPadIOVdd
**.ends

* expanding   symbol:  sg13g2_Corner_noptap.sym # of pins=7
** sym_path: /home/admin/work/IHP__MSPHY8281/dependencies/padring/xschem/openpdk-libraries/ihp-sg13g2/sg13g2_io/xschem/sg13g2_Corner_noptap.sym
** sch_path: /home/admin/work/IHP__MSPHY8281/dependencies/padring/xschem/openpdk-libraries/ihp-sg13g2/sg13g2_io/xschem/sg13g2_Corner_noptap.sch
.subckt sg13g2_Corner_noptap iovdd vdd vss sub iovss1 iovss3 iovss2
*.iopin vss
*.iopin iovdd
*.iopin vdd
*.iopin sub
*.iopin iovss1
*.iopin iovss2
*.iopin iovss3
* noconn iovdd
* noconn vdd
.ends

* expanding   symbol:  sg13g2_IOPadAnalog.sym # of pins=8
** sym_path: /home/admin/work/IHP__MSPHY8281/dependencies/padring/xschem/openpdk-libraries/ihp-sg13g2/sg13g2_io/xschem/sg13g2_IOPadAnalog.sym
** sch_path: /home/admin/work/IHP__MSPHY8281/dependencies/padring/xschem/openpdk-libraries/ihp-sg13g2/sg13g2_io/xschem/sg13g2_IOPadAnalog.sch
.subckt sg13g2_IOPadAnalog iovdd1 vss pad vdd ! padres iovss iovdd
*.iopin padres
*.iopin iovdd
*.iopin vss
*.iopin vdd
*.iopin !
*.iopin iovss
*.iopin pad
*.iopin iovdd1
XR2 vss ! ptap1 R=22.54 w=4.89e-6 l=4.89e-6
x1 iovdd iovss pad pad pad pad pad pad pad pad pad pad ! sg13g2_Clamp_P20N0D_noptap
x2 iovdd ! pad pad ! sg13g2_DCPDiode_noptap
x3 iovss pad pad pad pad pad pad pad pad pad pad ! sg13g2_Clamp_N20N0D
x4 pad iovss pad iovdd ! sg13g2_DCNDiode
x5 padres iovdd1 iovss pad ! sg13g2_SecondaryProtection
* noconn vdd
XR1 iovss ! ptap1 R=0.2112 w=66.14e-6 l=66.14e-6
.ends

* expanding   symbol:  sg13g2_IOPadVss.sym # of pins=6
** sym_path: /home/admin/work/IHP__MSPHY8281/dependencies/padring/xschem/openpdk-libraries/ihp-sg13g2/sg13g2_io/xschem/sg13g2_IOPadVss.sym
** sch_path: /home/admin/work/IHP__MSPHY8281/dependencies/padring/xschem/openpdk-libraries/ihp-sg13g2/sg13g2_io/xschem/sg13g2_IOPadVss.sch
.subckt sg13g2_IOPadVss vss vdd sub iovss iovdd iovss1
*.iopin iovdd
*.iopin vss
*.iopin vdd
*.iopin sub
*.iopin iovss
*.iopin iovss1
XR2 vss sub ptap1 R=22.47 w=4.9e-6 l=4.9e-6
x2 iovdd sub vss vss sub sg13g2_DCPDiode_noptap
x4 vss iovss vss iovdd sub sg13g2_DCNDiode
* noconn vdd
XR1 iovss1 sub ptap1 R=0.1719 w=73.54e-6 l=73.54e-6
.ends

* expanding   symbol:  sg13g2_Filler4000.sym # of pins=7
** sym_path: /home/admin/work/IHP__MSPHY8281/dependencies/padring/xschem/openpdk-libraries/ihp-sg13g2/sg13g2_io/xschem/sg13g2_Filler4000.sym
** sch_path: /home/admin/work/IHP__MSPHY8281/dependencies/padring/xschem/openpdk-libraries/ihp-sg13g2/sg13g2_io/xschem/sg13g2_Filler4000.sch
.subckt sg13g2_Filler4000 iovdd iovss1 vdd iovss2 iovss3 vss sub
*.iopin iovss1
*.iopin iovss2
*.iopin iovss3
*.iopin vss
*.iopin iovdd
*.iopin vdd
*.iopin sub
XR3 iovss3 sub ptap1 R=1.7 w=19.5e-6 l=25e-6
XR4 vss sub ptap1 R=21.56 w=0.3e-6 l=19.5e-6
* noconn iovdd
* noconn vdd
XR1 iovss1 sub ptap1 R=1.7 w=19.5e-6 l=25e-6
XR2 iovss2 sub ptap1 R=1.7 w=19.5e-6 l=25e-6
.ends

* expanding   symbol:  sg13g2_Filler1000.sym # of pins=7
** sym_path: /home/admin/work/IHP__MSPHY8281/dependencies/padring/xschem/openpdk-libraries/ihp-sg13g2/sg13g2_io/xschem/sg13g2_Filler1000.sym
** sch_path: /home/admin/work/IHP__MSPHY8281/dependencies/padring/xschem/openpdk-libraries/ihp-sg13g2/sg13g2_io/xschem/sg13g2_Filler1000.sch
.subckt sg13g2_Filler1000 iovdd iovss1 vdd iovss2 iovss3 vss sub
*.iopin iovss1
*.iopin iovss2
*.iopin iovss3
*.iopin vss
*.iopin iovdd
*.iopin vdd
*.iopin sub
XR3 iovss3 sub ptap1 R=5.806 w=4.4e-6 l=25e-6
XR4 vss sub ptap1 R=87.86 w=0.31e-6 l=4.56e-6
* noconn iovdd
* noconn vdd
XR1 iovss1 sub ptap1 R=5.806 w=4.4e-6 l=25e-6
XR2 iovss2 sub ptap1 R=5.806 w=4.4e-6 l=25e-6
.ends

* expanding   symbol:  sg13g2_Filler400.sym # of pins=7
** sym_path: /home/admin/work/IHP__MSPHY8281/dependencies/padring/xschem/openpdk-libraries/ihp-sg13g2/sg13g2_io/xschem/sg13g2_Filler400.sym
** sch_path: /home/admin/work/IHP__MSPHY8281/dependencies/padring/xschem/openpdk-libraries/ihp-sg13g2/sg13g2_io/xschem/sg13g2_Filler400.sch
.subckt sg13g2_Filler400 iovdd iovss1 vdd iovss2 iovss3 vss sub
*.iopin iovss1
*.iopin iovss2
*.iopin iovss3
*.iopin vss
*.iopin iovdd
*.iopin vdd
*.iopin sub
XR3 iovss3 sub ptap1 R=10.85 w=1.56e-6 l=24.5e-6
XR4 vss sub ptap1 R=208 w=0.42e-6 l=1.6e-6
* noconn iovdd
* noconn vdd
XR1 iovss1 sub ptap1 R=10.85 w=1.56e-6 l=24.5e-6
XR2 iovss2 sub ptap1 R=10.85 w=1.56e-6 l=24.5e-6
.ends

* expanding   symbol:  sg13g2_Filler200.sym # of pins=7
** sym_path: /home/admin/work/IHP__MSPHY8281/dependencies/padring/xschem/openpdk-libraries/ihp-sg13g2/sg13g2_io/xschem/sg13g2_Filler200.sym
** sch_path: /home/admin/work/IHP__MSPHY8281/dependencies/padring/xschem/openpdk-libraries/ihp-sg13g2/sg13g2_io/xschem/sg13g2_Filler200.sch
.subckt sg13g2_Filler200 iovdd iovss1 vdd iovss2 iovss3 vss sub
*.iopin iovss1
*.iopin iovss2
*.iopin iovss3
*.iopin vss
*.iopin iovdd
*.iopin vdd
*.iopin sub
XR3 iovss3 sub ptap1 R=15.35 w=0.56e-6 l=24.5e-6
XR4 vss sub ptap1 R=182.8 w=0.34e-6 l=2.0e-6
XR1 iovss1 sub ptap1 R=15.35 w=0.56e-6 l=24.5e-6
XR2 iovss2 sub ptap1 R=15.35 w=0.56e-6 l=24.5e-6
* noconn iovdd
* noconn vdd
.ends

* expanding   symbol:  sg13g2_IOPadVdd.sym # of pins=6
** sym_path: /home/admin/work/IHP__MSPHY8281/dependencies/padring/xschem/openpdk-libraries/ihp-sg13g2/sg13g2_io/xschem/sg13g2_IOPadVdd.sym
** sch_path: /home/admin/work/IHP__MSPHY8281/dependencies/padring/xschem/openpdk-libraries/ihp-sg13g2/sg13g2_io/xschem/sg13g2_IOPadVdd.sch
.subckt sg13g2_IOPadVdd vss vdd ! iovss iovdd iovss1
*.iopin iovdd
*.iopin vss
*.iopin vdd
*.iopin !
*.iopin iovss1
*.iopin iovss
XR2 vss ! ptap1 R=22.47 w=4.9e-6 l=4.9e-6
XR1 iovss1 ! ptap1 R=0.4388 w=45.3e-6 l=45.3e-6
x1 iovss vdd vdd vdd vdd vdd vdd vdd vdd vdd vdd vdd vdd vdd vdd vdd vdd vdd vdd vdd vdd vdd vdd ! net2 sg13g2_Clamp_N43N43D4R
x2 vdd net1 ! sg13g2_RCClampResistor
x3 vdd iovss1 net1 net2 ! sg13g2_RCClampInverter_noptap
* noconn iovdd
.ends

* expanding   symbol:  sg13g2_IOPadIOVdd.sym # of pins=6
** sym_path: /home/admin/work/IHP__MSPHY8281/dependencies/padring/xschem/openpdk-libraries/ihp-sg13g2/sg13g2_io/xschem/sg13g2_IOPadIOVdd.sym
** sch_path: /home/admin/work/IHP__MSPHY8281/dependencies/padring/xschem/openpdk-libraries/ihp-sg13g2/sg13g2_io/xschem/sg13g2_IOPadIOVdd.sch
.subckt sg13g2_IOPadIOVdd vss vdd ! iovss iovdd iovss1
*.iopin iovdd
*.iopin vss
*.iopin vdd
*.iopin !
*.iopin iovss1
*.iopin iovss
XR2 vss ! ptap1 R=22.47 w=4.9e-6 l=4.9e-6
* noconn vdd
XR1 iovss1 ! ptap1 R=0.4388 w=45.3e-6 l=45.3e-6
x1 iovss iovdd iovdd iovdd iovdd iovdd iovdd iovdd iovdd iovdd iovdd iovdd iovdd iovdd iovdd iovdd iovdd iovdd iovdd iovdd iovdd
+ iovdd iovdd ! net2 sg13g2_Clamp_N43N43D4R
x2 iovdd net1 ! sg13g2_RCClampResistor
x3 iovdd iovss1 net1 net2 ! sg13g2_RCClampInverter_noptap
.ends

* expanding   symbol:  sg13g2_IOPadIOVss.sym # of pins=5
** sym_path: /home/admin/work/IHP__MSPHY8281/dependencies/padring/xschem/openpdk-libraries/ihp-sg13g2/sg13g2_io/xschem/sg13g2_IOPadIOVss.sym
** sch_path: /home/admin/work/IHP__MSPHY8281/dependencies/padring/xschem/openpdk-libraries/ihp-sg13g2/sg13g2_io/xschem/sg13g2_IOPadIOVss.sch
.subckt sg13g2_IOPadIOVss vss vdd sub iovss iovdd
*.iopin iovdd
*.iopin vss
*.iopin vdd
*.iopin sub
*.iopin iovss
XR2 vss sub ptap1 R=22.47 w=4.9e-6 l=4.9e-6
* noconn vdd
XR1 iovss sub ptap1 R=0.1716 w=73.6e-6 l=73.6e-6
x2 iovdd sub iovss iovss sub sg13g2_DCPDiode_noptap
x1 iovss iovss iovss iovdd sub sg13g2_DCNDiode
.ends

* expanding   symbol:  sg13g2_IOPadIn.sym # of pins=8
** sym_path: /home/admin/work/IHP__MSPHY8281/dependencies/padring/xschem/openpdk-libraries/ihp-sg13g2/sg13g2_io/xschem/sg13g2_IOPadIn.sym
** sch_path: /home/admin/work/IHP__MSPHY8281/dependencies/padring/xschem/openpdk-libraries/ihp-sg13g2/sg13g2_io/xschem/sg13g2_IOPadIn.sch
.subckt sg13g2_IOPadIn vss vdd ! iovss iovdd iovss1 pad p2c
*.iopin iovdd
*.iopin vss
*.iopin vdd
*.iopin !
*.iopin iovss
*.iopin iovss1
*.iopin pad
*.iopin p2c
XR2 vss ! ptap1 R=22.47 w=4.9e-6 l=4.9e-6
XR1 iovss1 ! ptap1 R=0.1716 w=73.6e-6 l=73.6e-6
x4 iovdd iovss1 pad p2c vdd vss ! sg13g2_LevelDown_noptap
x2 iovdd ! pad pad ! sg13g2_DCPDiode_noptap
x1 pad iovss pad iovdd ! sg13g2_DCNDiode
.ends

* expanding   symbol:  sg13g2_IOPadOut30mA.sym # of pins=8
** sym_path: /home/admin/work/IHP__MSPHY8281/dependencies/padring/xschem/openpdk-libraries/ihp-sg13g2/sg13g2_io/xschem/sg13g2_IOPadOut30mA.sym
** sch_path: /home/admin/work/IHP__MSPHY8281/dependencies/padring/xschem/openpdk-libraries/ihp-sg13g2/sg13g2_io/xschem/sg13g2_IOPadOut30mA.sch
.subckt sg13g2_IOPadOut30mA vss vdd sub iovss iovdd1 c2p pad iovdd
*.iopin iovdd1
*.iopin vss
*.iopin vdd
*.iopin sub
*.iopin iovss
*.iopin iovdd
*.iopin pad
*.iopin c2p
XR2 vss sub ptap1 R=22.47 w=4.9e-6 l=4.9e-6
XR1 iovss sub ptap1 R=0.2094 w=66.44e-6 l=66.44e-6
x2 iovdd sub pad pad sub sg13g2_DCPDiode_noptap
x1 pad iovss pad iovdd sub sg13g2_DCNDiode
x3 iovdd1 vss c2p net1 vdd sub net2 sg13g2_GateLevelUpInv_noptap
x4 pad pad pad pad pad pad pad pad iovss sub net2 sg13g2_Clamp_N15N15D
x5 net1 iovdd iovss pad pad pad pad pad pad pad pad sub sg13g2_Clamp_P15N15D_noptap
.ends

* expanding   symbol:  sg13g2_Clamp_P20N0D_noptap.sym # of pins=4
** sym_path: /home/admin/work/IHP__MSPHY8281/dependencies/padring/xschem/openpdk-libraries/ihp-sg13g2/sg13g2_io/xschem/sg13g2_Clamp_P20N0D_noptap.sym
** sch_path: /home/admin/work/IHP__MSPHY8281/dependencies/padring/xschem/openpdk-libraries/ihp-sg13g2/sg13g2_io/xschem/sg13g2_Clamp_P20N0D_noptap.sch
.subckt sg13g2_Clamp_P20N0D_noptap ! iovss pad[9] pad[8] pad[7] pad[6] pad[5] pad[4] pad[3] pad[2] pad[1] pad[0] sub
*.iopin iovss
*.iopin !
*.iopin pad[9],pad[8],pad[7],pad[6],pad[5],pad[4],pad[3],pad[2],pad[1],pad[0]
*.iopin sub
XM1 pad[0] net1 ! ! sg13_hv_pmos w=26.64u l=0.6u ng=4 m=1
XM2 pad[1] net1 ! ! sg13_hv_pmos w=26.64u l=0.6u ng=4 m=1
XM3 pad[2] net1 ! ! sg13_hv_pmos w=26.64u l=0.6u ng=4 m=1
XM4 pad[3] net1 ! ! sg13_hv_pmos w=26.64u l=0.6u ng=4 m=1
XM5 pad[4] net1 ! ! sg13_hv_pmos w=26.64u l=0.6u ng=4 m=1
XM6 pad[5] net1 ! ! sg13_hv_pmos w=26.64u l=0.6u ng=4 m=1
XM7 pad[6] net1 ! ! sg13_hv_pmos w=26.64u l=0.6u ng=4 m=1
XM8 pad[7] net1 ! ! sg13_hv_pmos w=26.64u l=0.6u ng=4 m=1
XM9 pad[8] net1 ! ! sg13_hv_pmos w=26.64u l=0.6u ng=4 m=1
XM10 pad[9] net1 ! ! sg13_hv_pmos w=26.64u l=0.6u ng=4 m=1
XR1 ! net1 sub! rppd w=0.5e-6 l=12.9e-6 m=1 b=0
.ends

* expanding   symbol:  sg13g2_DCPDiode_noptap.sym # of pins=5
** sym_path: /home/admin/work/IHP__MSPHY8281/dependencies/padring/xschem/openpdk-libraries/ihp-sg13g2/sg13g2_io/xschem/sg13g2_DCPDiode_noptap.sym
** sch_path: /home/admin/work/IHP__MSPHY8281/dependencies/padring/xschem/openpdk-libraries/ihp-sg13g2/sg13g2_io/xschem/sg13g2_DCPDiode_noptap.sch
.subckt sg13g2_DCPDiode_noptap cathode guard anode1 anode2 sub
*.iopin anode2
*.iopin cathode
*.iopin guard
*.iopin anode1
*.iopin sub
XD1 anode1 cathode dpantenna l=27.78u w=1.26u
XD2 anode2 cathode dpantenna l=27.78u w=1.26u
.ends

* expanding   symbol:  sg13g2_Clamp_N20N0D.sym # of pins=3
** sym_path: /home/admin/work/IHP__MSPHY8281/dependencies/padring/xschem/openpdk-libraries/ihp-sg13g2/sg13g2_io/xschem/sg13g2_Clamp_N20N0D.sym
** sch_path: /home/admin/work/IHP__MSPHY8281/dependencies/padring/xschem/openpdk-libraries/ihp-sg13g2/sg13g2_io/xschem/sg13g2_Clamp_N20N0D.sch
.subckt sg13g2_Clamp_N20N0D iovss pad[9] pad[8] pad[7] pad[6] pad[5] pad[4] pad[3] pad[2] pad[1] pad[0] !
*.iopin iovss
*.iopin pad[9],pad[8],pad[7],pad[6],pad[5],pad[4],pad[3],pad[2],pad[1],pad[0]
*.iopin !
XR1 iovss ! ptap1 R=11.44 w=7.47e-6 l=7.47e-6
XM1 pad[0] net1 iovss ! sg13_hv_nmos w=8.8u l=0.6u ng=2 m=1
XM2 pad[1] net1 iovss ! sg13_hv_nmos w=8.8u l=0.6u ng=2 m=1
XM3 pad[2] net1 iovss ! sg13_hv_nmos w=8.8u l=0.6u ng=2 m=1
XM4 pad[3] net1 iovss ! sg13_hv_nmos w=8.8u l=0.6u ng=2 m=1
XM5 pad[4] net1 iovss ! sg13_hv_nmos w=8.8u l=0.6u ng=2 m=1
XM6 pad[5] net1 iovss ! sg13_hv_nmos w=8.8u l=0.6u ng=2 m=1
XM7 pad[6] net1 iovss ! sg13_hv_nmos w=8.8u l=0.6u ng=2 m=1
XM8 pad[7] net1 iovss ! sg13_hv_nmos w=8.8u l=0.6u ng=2 m=1
XM9 pad[8] net1 iovss ! sg13_hv_nmos w=8.8u l=0.6u ng=2 m=1
XM10 pad[9] net1 iovss ! sg13_hv_nmos w=8.8u l=0.6u ng=2 m=1
XR3 net1 iovss sub! rppd w=0.5e-6 l=3.54e-6 m=1 b=0
.ends

* expanding   symbol:  sg13g2_DCNDiode.sym # of pins=5
** sym_path: /home/admin/work/IHP__MSPHY8281/dependencies/padring/xschem/openpdk-libraries/ihp-sg13g2/sg13g2_io/xschem/sg13g2_DCNDiode.sym
** sch_path: /home/admin/work/IHP__MSPHY8281/dependencies/padring/xschem/openpdk-libraries/ihp-sg13g2/sg13g2_io/xschem/sg13g2_DCNDiode.sch
.subckt sg13g2_DCNDiode cathode1 anode cathode2 guard sub
*.iopin cathode2
*.iopin guard
*.iopin anode
*.iopin cathode1
*.iopin sub
XR1 anode sub ptap1 R=5.179 w=11.9e-6 l=11.9e-6
XD1 sub cathode1 dantenna l=27.78u w=1.26u
* noconn guard
XD2 sub cathode2 dantenna l=27.78u w=1.26u
.ends

* expanding   symbol:  sg13g2_SecondaryProtection.sym # of pins=5
** sym_path: /home/admin/work/IHP__MSPHY8281/dependencies/padring/xschem/openpdk-libraries/ihp-sg13g2/sg13g2_io/xschem/sg13g2_SecondaryProtection.sym
** sch_path: /home/admin/work/IHP__MSPHY8281/dependencies/padring/xschem/openpdk-libraries/ihp-sg13g2/sg13g2_io/xschem/sg13g2_SecondaryProtection.sch
.subckt sg13g2_SecondaryProtection core iovdd iovss pad !
*.iopin iovss
*.iopin core
*.iopin pad
*.iopin iovdd
*.iopin !
XR1 iovss ! ptap1 R=46.56 w=3.005e-6 l=3.005e-6
XD1 core iovdd dpantenna l=4.98u w=0.64u
XD2 ! core dantenna l=3.1u w=0.64u
XR3 pad core sub! rppd w=1e-6 l=2e-6 m=1 b=0
.ends

* expanding   symbol:  sg13g2_Clamp_N43N43D4R.sym # of pins=4
** sym_path: /home/admin/work/IHP__MSPHY8281/dependencies/padring/xschem/openpdk-libraries/ihp-sg13g2/sg13g2_io/xschem/sg13g2_Clamp_N43N43D4R.sym
** sch_path: /home/admin/work/IHP__MSPHY8281/dependencies/padring/xschem/openpdk-libraries/ihp-sg13g2/sg13g2_io/xschem/sg13g2_Clamp_N43N43D4R.sch
.subckt sg13g2_Clamp_N43N43D4R iovss pad[21] pad[20] pad[19] pad[18] pad[17] pad[16] pad[15] pad[14] pad[13] pad[12] pad[11]
+ pad[10] pad[9] pad[8] pad[7] pad[6] pad[5] pad[4] pad[3] pad[2] pad[1] pad[0] sub gate
*.iopin iovss
*.iopin
*+ pad[21],pad[20],pad[19],pad[18],pad[17],pad[16],pad[15],pad[14],pad[13],pad[12],pad[11],pad[10],pad[9],pad[8],pad[7],pad[6],pad[5],pad[4],pad[3],pad[2],pad[1],pad[0]
*.iopin sub
*.iopin gate
XR1 iovss sub ptap1 R=9.999 w=8.1e-6 l=8.1e-6
XM1 pad[11] gate iovss sub sg13_hv_nmos w=35.2u l=0.6u ng=8 m=1
XM2 pad[12] gate iovss sub sg13_hv_nmos w=35.2u l=0.6u ng=8 m=1
XM3 pad[13] gate iovss sub sg13_hv_nmos w=35.2u l=0.6u ng=8 m=1
XM4 pad[14] gate iovss sub sg13_hv_nmos w=35.2u l=0.6u ng=8 m=1
XM5 pad[15] gate iovss sub sg13_hv_nmos w=35.2u l=0.6u ng=8 m=1
XM6 pad[16] gate iovss sub sg13_hv_nmos w=35.2u l=0.6u ng=8 m=1
XM7 pad[17] gate iovss sub sg13_hv_nmos w=35.2u l=0.6u ng=8 m=1
XM8 pad[18] gate iovss sub sg13_hv_nmos w=35.2u l=0.6u ng=8 m=1
XM9 pad[19] gate iovss sub sg13_hv_nmos w=35.2u l=0.6u ng=8 m=1
XM10 pad[20] gate iovss sub sg13_hv_nmos w=35.2u l=0.6u ng=8 m=1
XM11 pad[21] gate iovss sub sg13_hv_nmos w=17.6u l=0.6u ng=4 m=1
XD1 sub gate dantenna l=0.48u w=0.48u
XM12 pad[0] gate iovss sub sg13_hv_nmos w=35.2u l=0.6u ng=8 m=1
XM13 pad[1] gate iovss sub sg13_hv_nmos w=35.2u l=0.6u ng=8 m=1
XM14 pad[2] gate iovss sub sg13_hv_nmos w=35.2u l=0.6u ng=8 m=1
XM15 pad[3] gate iovss sub sg13_hv_nmos w=35.2u l=0.6u ng=8 m=1
XM16 pad[4] gate iovss sub sg13_hv_nmos w=35.2u l=0.6u ng=8 m=1
XM17 pad[5] gate iovss sub sg13_hv_nmos w=35.2u l=0.6u ng=8 m=1
XM18 pad[6] gate iovss sub sg13_hv_nmos w=35.2u l=0.6u ng=8 m=1
XM19 pad[7] gate iovss sub sg13_hv_nmos w=35.2u l=0.6u ng=8 m=1
XM20 pad[8] gate iovss sub sg13_hv_nmos w=35.2u l=0.6u ng=8 m=1
XM21 pad[9] gate iovss sub sg13_hv_nmos w=35.2u l=0.6u ng=8 m=1
XM22 pad[10] gate iovss sub sg13_hv_nmos w=35.2u l=0.6u ng=8 m=1
.ends

* expanding   symbol:  sg13g2_RCClampResistor.sym # of pins=3
** sym_path: /home/admin/work/IHP__MSPHY8281/dependencies/padring/xschem/openpdk-libraries/ihp-sg13g2/sg13g2_io/xschem/sg13g2_RCClampResistor.sym
** sch_path: /home/admin/work/IHP__MSPHY8281/dependencies/padring/xschem/openpdk-libraries/ihp-sg13g2/sg13g2_io/xschem/sg13g2_RCClampResistor.sch
.subckt sg13g2_RCClampResistor p1 p2 !
*.iopin p1
*.iopin p2
*.iopin !
XR1 p1 p2 sub! rppd w=1e-6 l=520e-6 m=1 b=0
.ends

* expanding   symbol:  sg13g2_RCClampInverter_noptap.sym # of pins=5
** sym_path: /home/admin/work/IHP__MSPHY8281/dependencies/padring/xschem/openpdk-libraries/ihp-sg13g2/sg13g2_io/xschem/sg13g2_RCClampInverter_noptap.sym
** sch_path: /home/admin/work/IHP__MSPHY8281/dependencies/padring/xschem/openpdk-libraries/ihp-sg13g2/sg13g2_io/xschem/sg13g2_RCClampInverter_noptap.sch
.subckt sg13g2_RCClampInverter_noptap supply iovss in out sub
*.iopin supply
*.iopin iovss
*.iopin out
*.iopin in
*.iopin sub
XM1 iovss in iovss sub sg13_hv_nmos w=126u l=9.5u ng=14 m=1
XM2 out in iovss sub sg13_hv_nmos w=108u l=0.5u ng=12 m=1
XM3 out in supply supply sg13_hv_pmos w=350u l=0.5u ng=50 m=1
.ends

* expanding   symbol:  sg13g2_LevelDown_noptap.sym # of pins=7
** sym_path: /home/admin/work/IHP__MSPHY8281/dependencies/padring/xschem/openpdk-libraries/ihp-sg13g2/sg13g2_io/xschem/sg13g2_LevelDown_noptap.sym
** sch_path: /home/admin/work/IHP__MSPHY8281/dependencies/padring/xschem/openpdk-libraries/ihp-sg13g2/sg13g2_io/xschem/sg13g2_LevelDown_noptap.sch
.subckt sg13g2_LevelDown_noptap iovdd iovss pad core vdd vss !
*.iopin iovdd
*.iopin vss
*.iopin core
*.iopin pad
*.iopin vdd
*.iopin iovss
*.iopin !
XM5 net2 net1 vdd vdd sg13_hv_pmos w=4.65u l=0.45u ng=1 m=1
XM6 net2 net1 vss ! sg13_hv_nmos w=2.65u l=0.45u ng=1 m=1
XM7 core net2 vss ! sg13_lv_nmos w=2.75u l=0.13u ng=1 m=1
XM8 core net2 vdd vdd sg13_lv_pmos w=4.75u l=0.13u ng=1 m=1
x1 net1 iovdd iovss pad ! sg13g2_SecondaryProtection_noptap
.ends

* expanding   symbol:  sg13g2_GateLevelUpInv_noptap.sym # of pins=7
** sym_path: /home/admin/work/IHP__MSPHY8281/dependencies/padring/xschem/openpdk-libraries/ihp-sg13g2/sg13g2_io/xschem/sg13g2_GateLevelUpInv_noptap.sym
** sch_path: /home/admin/work/IHP__MSPHY8281/dependencies/padring/xschem/openpdk-libraries/ihp-sg13g2/sg13g2_io/xschem/sg13g2_GateLevelUpInv_noptap.sch
.subckt sg13g2_GateLevelUpInv_noptap iovdd vss core pgate vdd sub ngate
*.iopin iovdd
*.iopin vss
*.iopin pgate
*.iopin core
*.iopin vdd
*.iopin sub
*.iopin ngate
x1 iovdd vss core pgate vdd sub sg13g2_LevelUpInv_noptap
x2 iovdd vss core ngate vdd sub sg13g2_LevelUpInv_noptap
.ends

* expanding   symbol:  sg13g2_Clamp_N15N15D.sym # of pins=4
** sym_path: /home/admin/work/IHP__MSPHY8281/dependencies/padring/xschem/openpdk-libraries/ihp-sg13g2/sg13g2_io/xschem/sg13g2_Clamp_N15N15D.sym
** sch_path: /home/admin/work/IHP__MSPHY8281/dependencies/padring/xschem/openpdk-libraries/ihp-sg13g2/sg13g2_io/xschem/sg13g2_Clamp_N15N15D.sch
.subckt sg13g2_Clamp_N15N15D pad[7] pad[6] pad[5] pad[4] pad[3] pad[2] pad[1] pad[0] iovss sub gate
*.iopin iovss
*.iopin gate
*.iopin pad[7],pad[6],pad[5],pad[4],pad[3],pad[2],pad[1],pad[0]
*.iopin sub
XR1 iovss sub ptap1 R=11.44 w=7.47e-6 l=7.47e-6
XD1 sub gate dantenna l=0.78u w=0.78u
XM1 pad[0] gate iovss sub sg13_hv_nmos w=8.8u l=0.6u ng=2 m=1
XM2 pad[1] gate iovss sub sg13_hv_nmos w=8.8u l=0.6u ng=2 m=1
XM3 pad[2] gate iovss sub sg13_hv_nmos w=8.8u l=0.6u ng=2 m=1
XM4 pad[3] gate iovss sub sg13_hv_nmos w=8.8u l=0.6u ng=2 m=1
XM5 pad[4] gate iovss sub sg13_hv_nmos w=8.8u l=0.6u ng=2 m=1
XM6 pad[5] gate iovss sub sg13_hv_nmos w=8.8u l=0.6u ng=2 m=1
XM7 pad[6] gate iovss sub sg13_hv_nmos w=8.8u l=0.6u ng=2 m=1
XM8 pad[7] gate iovss sub sg13_hv_nmos w=4.4u l=0.6u ng=1 m=1
.ends

* expanding   symbol:  sg13g2_Clamp_P15N15D_noptap.sym # of pins=5
** sym_path: /home/admin/work/IHP__MSPHY8281/dependencies/padring/xschem/openpdk-libraries/ihp-sg13g2/sg13g2_io/xschem/sg13g2_Clamp_P15N15D_noptap.sym
** sch_path: /home/admin/work/IHP__MSPHY8281/dependencies/padring/xschem/openpdk-libraries/ihp-sg13g2/sg13g2_io/xschem/sg13g2_Clamp_P15N15D_noptap.sch
.subckt sg13g2_Clamp_P15N15D_noptap gate iovdd iovss pad[7] pad[6] pad[5] pad[4] pad[3] pad[2] pad[1] pad[0] sub
*.iopin iovss
*.iopin gate
*.iopin iovdd
*.iopin pad[7],pad[6],pad[5],pad[4],pad[3],pad[2],pad[1],pad[0]
*.iopin sub
XM1 pad[0] gate iovdd iovdd sg13_hv_pmos w=26.64u l=0.6u ng=4 m=1
XD1 gate iovdd dpantenna l=0.78u w=0.78u
XM2 pad[1] gate iovdd iovdd sg13_hv_pmos w=26.64u l=0.6u ng=4 m=1
XM3 pad[2] gate iovdd iovdd sg13_hv_pmos w=26.64u l=0.6u ng=4 m=1
XM4 pad[3] gate iovdd iovdd sg13_hv_pmos w=26.64u l=0.6u ng=4 m=1
XM5 pad[4] gate iovdd iovdd sg13_hv_pmos w=26.64u l=0.6u ng=4 m=1
XM6 pad[5] gate iovdd iovdd sg13_hv_pmos w=26.64u l=0.6u ng=4 m=1
XM7 pad[6] gate iovdd iovdd sg13_hv_pmos w=26.64u l=0.6u ng=4 m=1
XM8 pad[7] gate iovdd iovdd sg13_hv_pmos w=13.32u l=0.6u ng=2 m=1
.ends

* expanding   symbol:  sg13g2_SecondaryProtection_noptap.sym # of pins=5
** sym_path: /home/admin/work/IHP__MSPHY8281/dependencies/padring/xschem/openpdk-libraries/ihp-sg13g2/sg13g2_io/xschem/sg13g2_SecondaryProtection_noptap.sym
** sch_path: /home/admin/work/IHP__MSPHY8281/dependencies/padring/xschem/openpdk-libraries/ihp-sg13g2/sg13g2_io/xschem/sg13g2_SecondaryProtection_noptap.sch
.subckt sg13g2_SecondaryProtection_noptap core iovdd iovss pad !
*.iopin iovss
*.iopin core
*.iopin pad
*.iopin iovdd
*.iopin !
XD1 core iovdd dpantenna l=4.98u w=0.64u
XD2 ! core dantenna l=3.1u w=0.64u
XR1 core pad sub! rppd w=1e-6 l=2e-6 m=1 b=0
.ends

* expanding   symbol:  sg13g2_LevelUpInv_noptap.sym # of pins=6
** sym_path: /home/admin/work/IHP__MSPHY8281/dependencies/padring/xschem/openpdk-libraries/ihp-sg13g2/sg13g2_io/xschem/sg13g2_LevelUpInv_noptap.sym
** sch_path: /home/admin/work/IHP__MSPHY8281/dependencies/padring/xschem/openpdk-libraries/ihp-sg13g2/sg13g2_io/xschem/sg13g2_LevelUpInv_noptap.sch
.subckt sg13g2_LevelUpInv_noptap iovdd vss in out vdd sub
*.iopin iovdd
*.iopin vss
*.iopin out
*.iopin in
*.iopin vdd
*.iopin sub
XM1 net1 in vss sub sg13_hv_nmos w=1.9u l=0.45u ng=1 m=1
XM3 net1 net2 iovdd iovdd sg13_hv_pmos w=0.3u l=0.45u ng=1 m=1
XM4 net2 net1 iovdd iovdd sg13_hv_pmos w=0.3u l=0.45u ng=1 m=1
XM5 out net2 iovdd iovdd sg13_hv_pmos w=3.9u l=0.45u ng=1 m=1
XM2 net2 net3 vss sub sg13_hv_nmos w=1.9u l=0.45u ng=1 m=1
XM6 out net2 vss sub sg13_hv_nmos w=1.9u l=0.45u ng=1 m=1
XM7 net3 in vss sub sg13_lv_nmos w=2.75u l=0.13u ng=1 m=1
XM8 net3 in vdd vdd sg13_lv_pmos w=4.75u l=0.13u ng=1 m=1
.ends

.end
